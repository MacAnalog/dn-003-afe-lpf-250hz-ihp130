** sch_path: /home/noorizad/spicexplorer-workspace/external/agentic-design-250hz-lpf-ihp130/signoff/E-combo/lpf_tb_E_gd.sch
**.subckt lpf_tb_E_gd
vsig sig vcm dc 0 ac 1
vcm vcm 0 0.32
evp vinp vcm sig vcm 0.5
evn vinn vcm sig vcm -0.5
xdut vinp vinn voutp voutn vbn vbp vdd lpf_core_E
vflt vdd_top vdd 0
vdd_meas vdd_top 0 1.5
iref vdd_top vbn 1e-09
Xmbn vbn vbn 0 0 sg13_hv_nmos w=1e-05 l=1.6e-05 ng=1 m=1
Xmbp vbp vbn 0 0 sg13_hv_nmos w=1e-05 l=1.6e-05 ng=1 m=1
Xmbpd vbp vbp vdd_top vdd_top sg13_hv_pmos w=8e-06 l=8e-06 ng=1 m=1
**** begin user architecture code

.title lpf b -- group delay (single run)
.lib cornerMOShv.lib mos_tt
.lib cornerMOSlv.lib mos_tt
.nodeset v(xdut.vout_1)=0.8095 v(xdut.vout_2)=0.8095 v(voutp)=1.3421 v(voutn)=1.3421
.temp 27.0

.control
set filetype=binary
set appendwrite
save all @n.xdut.xm2.nsg13_hv_pmos[ids] @n.xdut.xm2.nsg13_hv_pmos[gm] @n.xdut.xm2.nsg13_hv_pmos[gds] @n.xdut.xm2.nsg13_hv_pmos[gmb] @n.xdut.xm2.nsg13_hv_pmos[vgs] @n.xdut.xm2.nsg13_hv_pmos[vds] @n.xdut.xm2.nsg13_hv_pmos[vth] @n.xdut.xm2.nsg13_hv_pmos[vdss] @n.xdut.xm2.nsg13_hv_pmos[cgg] @n.xdut.xm5.nsg13_hv_pmos[ids] @n.xdut.xm5.nsg13_hv_pmos[gm] @n.xdut.xm5.nsg13_hv_pmos[gds] @n.xdut.xm5.nsg13_hv_pmos[gmb] @n.xdut.xm5.nsg13_hv_pmos[vgs] @n.xdut.xm5.nsg13_hv_pmos[vds] @n.xdut.xm5.nsg13_hv_pmos[vth] @n.xdut.xm5.nsg13_hv_pmos[vdss] @n.xdut.xm5.nsg13_hv_pmos[cgg] @n.xdut.xm4.nsg13_hv_nmos[ids] @n.xdut.xm4.nsg13_hv_nmos[gm] @n.xdut.xm4.nsg13_hv_nmos[gds] @n.xdut.xm4.nsg13_hv_nmos[gmb] @n.xdut.xm4.nsg13_hv_nmos[vgs] @n.xdut.xm4.nsg13_hv_nmos[vds] @n.xdut.xm4.nsg13_hv_nmos[vth] @n.xdut.xm4.nsg13_hv_nmos[vdss] @n.xdut.xm4.nsg13_hv_nmos[cgg] @n.xdut.xm8.nsg13_hv_nmos[ids] @n.xdut.xm8.nsg13_hv_nmos[gm] @n.xdut.xm8.nsg13_hv_nmos[gds] @n.xdut.xm8.nsg13_hv_nmos[gmb] @n.xdut.xm8.nsg13_hv_nmos[vgs] @n.xdut.xm8.nsg13_hv_nmos[vds] @n.xdut.xm8.nsg13_hv_nmos[vth] @n.xdut.xm8.nsg13_hv_nmos[vdss] @n.xdut.xm8.nsg13_hv_nmos[cgg] @n.xdut.xm9.nsg13_hv_nmos[ids] @n.xdut.xm9.nsg13_hv_nmos[gm] @n.xdut.xm9.nsg13_hv_nmos[gds] @n.xdut.xm9.nsg13_hv_nmos[gmb] @n.xdut.xm9.nsg13_hv_nmos[vgs] @n.xdut.xm9.nsg13_hv_nmos[vds] @n.xdut.xm9.nsg13_hv_nmos[vth] @n.xdut.xm9.nsg13_hv_nmos[vdss] @n.xdut.xm9.nsg13_hv_nmos[cgg] @n.xdut.xm10.nsg13_hv_nmos[ids] @n.xdut.xm10.nsg13_hv_nmos[gm] @n.xdut.xm10.nsg13_hv_nmos[gds] @n.xdut.xm10.nsg13_hv_nmos[gmb] @n.xdut.xm10.nsg13_hv_nmos[vgs] @n.xdut.xm10.nsg13_hv_nmos[vds] @n.xdut.xm10.nsg13_hv_nmos[vth] @n.xdut.xm10.nsg13_hv_nmos[vdss] @n.xdut.xm10.nsg13_hv_nmos[cgg] @n.xdut.xmst.nsg13_hv_pmos[ids] @n.xdut.xmst.nsg13_hv_pmos[gm] @n.xdut.xmst.nsg13_hv_pmos[gds] @n.xdut.xmst.nsg13_hv_pmos[gmb] @n.xdut.xmst.nsg13_hv_pmos[vgs] @n.xdut.xmst.nsg13_hv_pmos[vds] @n.xdut.xmst.nsg13_hv_pmos[vth] @n.xdut.xmst.nsg13_hv_pmos[vdss] @n.xdut.xmst.nsg13_hv_pmos[cgg] @n.xdut.xmstn.nsg13_hv_pmos[ids] @n.xdut.xmstn.nsg13_hv_pmos[gm] @n.xdut.xmstn.nsg13_hv_pmos[gds] @n.xdut.xmstn.nsg13_hv_pmos[gmb] @n.xdut.xmstn.nsg13_hv_pmos[vgs] @n.xdut.xmstn.nsg13_hv_pmos[vds] @n.xdut.xmstn.nsg13_hv_pmos[vth] @n.xdut.xmstn.nsg13_hv_pmos[vdss] @n.xdut.xmstn.nsg13_hv_pmos[cgg] @n.xdut.xm0.nsg13_hv_pmos[ids] @n.xdut.xm0.nsg13_hv_pmos[gm] @n.xdut.xm0.nsg13_hv_pmos[gds] @n.xdut.xm0.nsg13_hv_pmos[gmb] @n.xdut.xm0.nsg13_hv_pmos[vgs] @n.xdut.xm0.nsg13_hv_pmos[vds] @n.xdut.xm0.nsg13_hv_pmos[vth] @n.xdut.xm0.nsg13_hv_pmos[vdss] @n.xdut.xm0.nsg13_hv_pmos[cgg] @n.xdut.xm1.nsg13_hv_pmos[ids] @n.xdut.xm1.nsg13_hv_pmos[gm] @n.xdut.xm1.nsg13_hv_pmos[gds] @n.xdut.xm1.nsg13_hv_pmos[gmb] @n.xdut.xm1.nsg13_hv_pmos[vgs] @n.xdut.xm1.nsg13_hv_pmos[vds] @n.xdut.xm1.nsg13_hv_pmos[vth] @n.xdut.xm1.nsg13_hv_pmos[vdss] @n.xdut.xm1.nsg13_hv_pmos[cgg] @n.xdut.xm14.nsg13_lv_pmos[ids] @n.xdut.xm14.nsg13_lv_pmos[gm] @n.xdut.xm14.nsg13_lv_pmos[gds] @n.xdut.xm14.nsg13_lv_pmos[gmb] @n.xdut.xm14.nsg13_lv_pmos[vgs] @n.xdut.xm14.nsg13_lv_pmos[vds] @n.xdut.xm14.nsg13_lv_pmos[vth] @n.xdut.xm14.nsg13_lv_pmos[vdss] @n.xdut.xm14.nsg13_lv_pmos[cgg] @n.xdut.xm15.nsg13_lv_pmos[ids] @n.xdut.xm15.nsg13_lv_pmos[gm] @n.xdut.xm15.nsg13_lv_pmos[gds] @n.xdut.xm15.nsg13_lv_pmos[gmb] @n.xdut.xm15.nsg13_lv_pmos[vgs] @n.xdut.xm15.nsg13_lv_pmos[vds] @n.xdut.xm15.nsg13_lv_pmos[vth] @n.xdut.xm15.nsg13_lv_pmos[vdss] @n.xdut.xm15.nsg13_lv_pmos[cgg]
op
write sim.raw
ac dec 50 0.1 1000
let hdiff = v(voutp) - v(voutn)
let hdb = db(mag(hdiff))
let dc_db = hdb[0]
let ph = cph(hdiff)
let gd = -deriv(ph) / (2 * pi)
let gd_dc_ms = gd[0] * 1e3
let gd_max_ms = vecmax(gd) * 1e3
let hrel = hdb - dc_db
meas ac fc_hz when hrel = -3 fall = 1
print dc_db gd_dc_ms gd_max_ms
write sim.raw hdiff ph gd frequency
.endc

**** end user architecture code
**.ends

* expanding   symbol:  lpf_core_E.sym # of pins=7
** sym_path: /home/noorizad/spicexplorer-workspace/external/agentic-design-250hz-lpf-ihp130/signoff/E-combo/lpf_core_E.sym
** sch_path: /home/noorizad/spicexplorer-workspace/external/agentic-design-250hz-lpf-ihp130/signoff/E-combo/lpf_core_E.sch
.subckt lpf_core_E vinp vinn voutp voutn vbn vbp vdd
*.ipin vinp
*.ipin vinn
*.opin voutp
*.opin voutn
*.ipin vdd
*.ipin vbn
*.ipin vbp
Xm2 net2 vinp vout_1 vout_1 sg13_hv_pmos w=8e-06 l=8e-06 ng=1 m=1
Xm5 net3 vinn vout_2 vout_2 sg13_hv_pmos w=8e-06 l=8e-06 ng=1 m=1
Xm4 vout_1 net2 0 0 sg13_hv_nmos w=1e-06 l=4.5e-05 ng=1 m=1
Xm8 vout_2 net3 0 0 sg13_hv_nmos w=1e-06 l=4.5e-05 ng=1 m=1
Xm9 net2 vbn 0 0 sg13_hv_nmos w=1e-05 l=1.6e-05 ng=1 m=1
Xm10 net3 vbn 0 0 sg13_hv_nmos w=1e-05 l=1.6e-05 ng=1 m=1
Xmst vout_1 vbn net4 net4 sg13_hv_pmos w=4.8e-07 l=3.36e-05 ng=1 m=1
Xmstn vout_2 vbn net1 net1 sg13_hv_pmos w=4.8e-07 l=3.36e-05 ng=1 m=1
Xm0 net4 vout_1 voutp voutp sg13_hv_pmos w=8e-06 l=8e-06 ng=1 m=1
Xm1 net1 vout_2 voutn voutn sg13_hv_pmos w=8e-06 l=8e-06 ng=1 m=1
Xm14 voutp net4 vdd vdd sg13_lv_pmos w=1.28e-06 l=9.6e-05 ng=1 m=1
Xm15 voutn net1 vdd vdd sg13_lv_pmos w=1.28e-06 l=9.6e-05 ng=1 m=1
c13 net2 vout_1 8.61884e-12 m=1
c17 net3 vout_2 8.61884e-12 m=1
c19 vout_2 vout_1 2.36443e-11 m=1
c1 voutp net4 8.10786e-11 m=1
c10 voutn net1 8.10786e-11 m=1
c12 voutn voutp 1.69787e-11 m=1
.ends

.end
