** sch_path: /home/noorizad/spicexplorer-workspace/external/agentic-design-250hz-lpf-ihp130/signoff/post-pvt/H12-robust/lpf_tb_H12.sch
**.subckt lpf_tb_H12
vsig sig vcm dc 0 ac 1
vcm vcm 0 0.24
evp vinp vcm sig vcm 0.5
evn vinn vcm sig vcm -0.5
xdut vinp vinn voutp voutn vbn vbp vdd lpf_core_H12
vflt vdd_top vdd 0
vdd_meas vdd_top 0 1.5
iref vdd_top vbn 6.624e-10
Xmbn vbn vbn 0 0 sg13_hv_nmos w=2.3885e-05 l=2.5475e-05 ng=17 m=1
Xmbp vbp vbn 0 0 sg13_hv_nmos w=2.3885e-05 l=2.5475e-05 ng=17 m=1
Xmbpd vbp vbp vdd_top vdd_top sg13_hv_pmos w=1.56e-05 l=1.04e-05 ng=2 m=1
**** begin user architecture code

.title lpf d -- ac + noise
.lib cornerMOShv.lib mos_tt
.nodeset v(xdut.vout_1)=0.6975 v(xdut.vout_2)=0.6975 v(voutp)=1.2811 v(voutn)=1.2811
.temp 27.0

.control
set filetype=binary
set appendwrite
op
write sim.raw
ac dec 50 0.1 100000
write sim.raw
noise v(voutp,voutn) vsig dec 50 0.1 1000
setplot noise1
write sim.raw
.endc

**** end user architecture code
**.ends

* expanding   symbol:  lpf_core_H12.sym # of pins=7
** sym_path: /home/noorizad/spicexplorer-workspace/external/agentic-design-250hz-lpf-ihp130/signoff/post-pvt/H12-robust/lpf_core_H12.sym
** sch_path: /home/noorizad/spicexplorer-workspace/external/agentic-design-250hz-lpf-ihp130/signoff/post-pvt/H12-robust/lpf_core_H12.sch
.subckt lpf_core_H12 vinp vinn voutp voutn vbn vbp vdd
*.ipin vinp
*.ipin vinn
*.opin voutp
*.opin voutn
*.ipin vdd
*.ipin vbn
*.ipin vbp
Xm2 net2 vinp vout_1 vout_1 sg13_hv_pmos w=1.56e-05 l=1.04e-05 ng=2 m=1
Xm5 net3 vinn vout_2 vout_2 sg13_hv_pmos w=1.56e-05 l=1.04e-05 ng=2 m=1
Xm4 vout_1 net2 0 0 sg13_hv_nmos w=1.5e-06 l=4.5e-05 ng=1 m=1
Xm8 vout_2 net3 0 0 sg13_hv_nmos w=1.5e-06 l=4.5e-05 ng=1 m=1
Xm9 net2 vbn 0 0 sg13_hv_nmos w=2.3885e-05 l=2.5475e-05 ng=17 m=1
Xm10 net3 vbn 0 0 sg13_hv_nmos w=2.3885e-05 l=2.5475e-05 ng=17 m=1
Xmst vout_1 vbr net4 net4 sg13_hv_pmos w=4.86e-06 l=3.276e-05 ng=1 m=1
Xmstn vout_2 vbr net1 net1 sg13_hv_pmos w=4.86e-06 l=3.276e-05 ng=1 m=1
Xm0 net4 vout_1 voutp voutp sg13_hv_pmos w=4e-06 l=1.5e-05 ng=1 m=1
Xm1 net1 vout_2 voutn voutn sg13_hv_pmos w=4e-06 l=1.5e-05 ng=1 m=1
Xm14 voutp net4 vdd vdd sg13_hv_pmos w=1.202e-05 l=3.1115e-05 ng=2 m=1
Xm15 voutn net1 vdd vdd sg13_hv_pmos w=1.202e-05 l=3.1115e-05 ng=2 m=1
Xr1 rep_x rep_x vdd vdd sg13_hv_pmos w=1.202e-05 l=3.1115e-05 ng=2 m=1
Xr2 vbr vbr rep_x rep_x sg13_hv_pmos w=4.86e-06 l=3.276e-05 ng=1 m=1
Xr3 vbr vbn 0 0 sg13_hv_nmos w=2.3885e-05 l=2.5475e-05 ng=17 m=4
c13 net2 vout_1 5.00659e-12 m=1
c17 net3 vout_2 5.00659e-12 m=1
c19 vout_2 vout_1 2.89483e-11 m=1
c1 voutp net4 6.0258e-11 m=1
c10 voutn net1 6.0258e-11 m=1
c12 voutn voutp 2.39864e-11 m=1
.ends

.end
