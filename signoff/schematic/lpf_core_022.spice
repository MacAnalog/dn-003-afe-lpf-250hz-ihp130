** sch_path: /sch/lpf_core_022.sch
**.subckt lpf_core_022 vinp vinn voutp voutn vdd vbp vbn
*.ipin vinp
*.ipin vinn
*.opin voutp
*.opin voutn
*.ipin vdd
*.ipin vbp
*.ipin vbn
Xm2 net2 vinp vout_1 vout_1 sg13_lv_pmos w=1.56e-05 l=1.04e-05 ng=1 m=1
Xm9 net2 vbn 0 0 sg13_hv_nmos w=2.925e-05 l=3.12e-05 ng=1 m=1
Xm4 vout_1 net2 0 0 sg13_hv_nmos w=7.8e-06 l=5.2e-06 ng=1 m=1
Xm5 net3 vinn vout_2 vout_2 sg13_lv_pmos w=1.56e-05 l=1.04e-05 ng=1 m=1
Xm10 net3 vbn 0 0 sg13_hv_nmos w=2.925e-05 l=3.12e-05 ng=1 m=1
Xm8 vout_2 net3 0 0 sg13_hv_nmos w=7.8e-06 l=5.2e-06 ng=1 m=1
Xm14 voutp net4 vdd vdd sg13_lv_pmos w=1.29324e-06 l=3.9e-05 ng=1 m=1
Xm0 net4 vout_1 voutp voutp sg13_hv_pmos w=1.56e-05 l=1.04e-05 ng=1 m=1
Xmst vout_1 vbn net4 net4 sg13_hv_pmos w=2.5896e-07 l=2.73e-05 ng=1 m=1
Xm15 voutn net1 vdd vdd sg13_lv_pmos w=1.29324e-06 l=3.9e-05 ng=1 m=1
Xm1 net1 vout_2 voutn voutn sg13_hv_pmos w=1.56e-05 l=1.04e-05 ng=1 m=1
Xmstn vout_2 vbn net1 net1 sg13_hv_pmos w=2.5896e-07 l=2.73e-05 ng=1 m=1
c13 net2 vout_1 8.46981e-12 m=1
c17 net3 vout_2 8.46981e-12 m=1
c19 vout_2 vout_1 5.73811e-11 m=1
c1 voutp net4 1.31527e-10 m=1
c10 voutn net1 1.31527e-10 m=1
c12 voutn voutp 2.88874e-11 m=1
**.ends
.end
